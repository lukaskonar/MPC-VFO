# Ansys Electronics Desktop project, version 2025.2
materials:
  copper: permeability=0.999991 conductivity=58000000
  FR4_epoxy: permittivity=4.4 dielectric_loss_tangent=0.02

design Circuit1 (Circuit)
options: SParamCircuitDef IntegrationMethod=FFT
variables:
  l1 = 1.4nH  # tune 0nH..5nH
components:
  S1 = ne68133i _1_2()
  L2 = IND_(L=l1)
  U4 = Circuit2()
  L7 = IND_(L=8.46nH)
  C8 = CAP_(C=22.3pF)
  L9 = IND_(L=19.7nH)
  port Port1 rz=50ohm iz=0ohm EnableNoise=false noisetemp=16.85cel
  port Port2 rz=50ohm iz=0ohm EnableNoise=false noisetemp=16.85cel
nets:
  0: L2.1, L7.0
  net_1: S1.ref, L2.0
  net_2: S1.0, C8.1
  net_3: S1.1, L9.0
  Port1: C8.0, L7.1
  Port2: L9.1
setups:
  LinearFrequency: LinearFrequencyData(false, 0.1, true, "", false) SweepDefinition{Variable=Freq Data="LIN 500MHz 1.5GHz 0.1GHz"}
reports:
  S Parameter Plot1: dB(S(Port1,Port1)), dB(S(Port2,Port1)), dB(S(Port2,Port2)), dB(MSG), dB(GMAX), dB(FMIN), dB(NF) vs Freq on LinearFrequency : LinearFrequency; markers MX1 at x=9.0016779e+08
  Stability Plot1: B1, K vs Freq on LinearFrequency : LinearFrequency; markers MX1 at x=9.0100671e+08
  S-Parameters2: S(Port1,Port1), S(Port2,Port2) on LinearFrequency : LinearFrequency [Freq=all]; KCS, KCL on LinearFrequency : LinearFrequency [Freq=0.9GHz]
  S Parameter Chart1: S(Port1,Port1), S(Port2,Port2) on LinearFrequency : LinearFrequency [Freq=all l1=all]

design Circuit2 (Circuit)
options: SParamCircuitDef IntegrationMethod=FFT
components:
  L5 = IND_(L=8.77nH)
  C6 = CAP_(C=19.79pF)
  port Port1 rz=50ohm iz=0ohm EnableNoise=false noisetemp=16.85cel
  port Port2 rz=50ohm iz=0ohm EnableNoise=false noisetemp=16.85cel
nets:
  0: L5.1
  Port1: C6.0, L5.0
  Port2: C6.1
