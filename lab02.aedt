# Ansys Electronics Desktop project, version 2025.2
materials:
  copper: permeability=0.999991 conductivity=58000000
  FR4_epoxy: permittivity=4.4 dielectric_loss_tangent=0.02

design Circuit1 (Circuit)
options: SParamCircuitDef IntegrationMethod=FFT
variables:
  w0 = 1.44mm
  l0 = 12mm
  wl = 0.4mm
  ll = 23mm
  wc = 4mm
  lc = 8.25mm
  llo = 16.2mm
  wco = 4mm
  lco = 10.5mm
  ll1 = (11.3*k3) mm
  ll2 = (4.97*k1) mm
  wc_ = 8.5mm
  lc2 = (18.6*k1) mm
  ll3 = (19.9*k3) mm
  ll4 = (9.616*k2) mm
  lc4 = (12.4*k2) mm
  ll5 = (18.2*k3) mm
  lc6 = (13.9*k3) mm
  k1 = 0.7  # tune 0.5..1.5
  k2 = 0.86  # tune 0.5..1.5
  k3 = 1  # tune 0.5..1.5
components:
  A1 = MS_TRL(W=w0 P=l0)
  A2 = MS_TRL(W=wl P=ll)
  A3 = MS_TRL(W=wc P=lc)
  A4 = MS_TRL(W=w0 P=l0)
  A5 = MS_TRL(W=wl P=ll)
  A6 = MS_TRL(W=w0 P=l0)
  A7 = MS_TRL(W=wl P=ll)
  A8 = MS_TRL(W=wc P=lc)
  A9 = MS_TRL(W=w0 P=l0)
  A10 = MS_TRL(W=wl P=ll)
  A23 = MS_STEP(W1=w0 W2=wl)
  A24 = MS_STEP(W1=wl W2=wc)
  A11 = MS_STEP(W1=wl W2=wc)
  A12 = MS_STEP(W1=w0 W2=wl)
  A13 = MS_TRL(W=w0 P=l0)
  A14 = MS_TRL(W=wl P=llo)
  A16 = MS_TRL(W=w0 P=l0)
  A17 = MS_TRL(W=wl P=llo)
  A18 = MS_STEP(W1=w0 W2=wl)
  A21 = MS_STEP(W1=w0 W2=wl)
  A50 = MS_TEEC(W1=wl W2=wl W3=wco)
  W51 = MS_OPEN_STUB(W=wco P=lco)
  A15 = MS_TRL(W=w0 P=l0)
  A19 = MS_TRL(W=wl P=ll1)
  A20 = MS_TRL(W=wl P=ll3)
  A22 = MS_STEP(W1=w0 W2=wl)
  A25 = MS_TEEC(W1=wl W2=wl W3=wl)
  W1 = MS_OPEN_STUB(W=wc P=lc2)
  A26 = MS_TRL(W=wl P=ll2)
  A27 = MS_STEP(W1=wc W2=wl)
  A28 = MS_TRL(W=wl P=ll5)
  A29 = MS_TEEC(W1=wl W2=wl W3=wl)
  W2 = MS_OPEN_STUB(W=wc P=lc4)
  A30 = MS_TRL(W=wl P=ll4)
  A31 = MS_STEP(W1=wc W2=wl)
  A32 = MS_TRL(W=wc P=lc6)
  A34 = MS_TRL(W=w0 P=l0)
  A35 = MS_STEP(W1=w0 W2=wc)
  A33 = MS_STEP(W1=wl W2=wc)
  port Port1 rz=50ohm iz=0ohm EnableNoise=false noisetemp=16.85cel
  port Port2 rz=50ohm iz=0ohm EnableNoise=false noisetemp=16.85cel
  port Port3 rz=50ohm iz=0ohm EnableNoise=false noisetemp=16.85cel
  port Port4 rz=50ohm iz=0ohm EnableNoise=false noisetemp=16.85cel
  port Port5 rz=50ohm iz=0ohm EnableNoise=false noisetemp=16.85cel
  port Port6 rz=50ohm iz=0ohm EnableNoise=false noisetemp=16.85cel
  port Port7 rz=50ohm iz=0ohm EnableNoise=false noisetemp=16.85cel
  port Port8 rz=50ohm iz=0ohm EnableNoise=false noisetemp=16.85cel
nets:
  net_1: A1.1, A2.0
  net_10: A24.1, A8.0
  net_11: A11.0, A10.1
  net_12: A9.1, A12.0
  net_13: A10.0, A12.1
  net_14: A11.1, A8.1
  net_15: A15.1, A22.0
  net_16: A50.0, A14.1
  net_17: W51.0, A50.2
  net_18: A21.0, A16.1
  net_19: A21.1, A17.0
  net_2: A2.1, A3.0
  net_20: A50.1, A17.1
  net_21: A22.1, A19.0
  net_22: A19.1, A25.0
  net_23: A27.1, A26.0
  net_24: A20.1, A25.1
  net_25: A26.1, A25.2
  net_26: A27.0, W1.0
  net_27: A28.1, A29.1
  net_28: A30.0, A31.1
  net_29: A30.1, A29.2
  net_3: A4.1, A5.0
  net_30: W2.0, A31.0
  net_33: A34.1, A35.0
  net_34: A32.0, A35.1
  net_35: A33.1, A32.1
  net_36: A28.0, A33.0
  net_37: A29.0, A20.0
  net_4: A3.1, A5.1
  net_5: A23.0, A6.1
  net_6: A23.1, A7.0
  net_7: A18.0, A13.1
  net_8: A14.0, A18.1
  net_9: A24.0, A7.1
  Port1: A1.0
  Port2: A4.0
  Port3: A6.0
  Port4: A9.0
  Port5: A13.0
  Port6: A16.0
  Port7: A15.0
  Port8: A34.0
setups:
  LinearFrequency: LinearFrequencyData(false, 0.1, false, "", false) SweepDefinition{Variable=Freq Data="LIN 0.1GHz 2.5GHz 0.01GHz"}
reports:
  S Parameter Plot1: dB(S(Port1,Port1)), dB(S(Port2,Port1)), dB(S(Port3,Port3)), dB(S(Port4,Port3)), dB(S(Port5,Port5)), dB(S(Port6,Port5)), dB(S(Port7,Port7)), dB(S(Port8,Port7)) vs Freq on LinearFrequency : LinearFrequency; markers MX1 at x=1.0113893e+09, MY1 at y=-46.9847
  S Parameter Plot2: dB(S(Port7,Port7)), dB(S(Port8,Port7)) vs Freq on LinearFrequency : LinearFrequency; markers MX1 at x=1.2809564e+09, MX2 at x=1.6431925e+09
