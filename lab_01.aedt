# Ansys Electronics Desktop project, version 2025.2
materials:
  copper: permeability=0.999991 conductivity=58000000
  FR4_epoxy: permittivity=4.4 dielectric_loss_tangent=0.02

design Circuit1 (Circuit)
options: SParamCircuitDef IntegrationMethod=FFT
variables:
  C1 = 1/(2*pi*fc*Rin)
  L1 = Rin*2/(2*pi*fc)
  C2 = 1/(2*pi*fc*Rin)
  Rin = 50mOhm
  fc = 100MHz
  C3 = (1.0316/(2*pi*fc*Rin)*k1) farad
  C4 = (1.0316/(2*pi*fc*Rin)*k1) farad
  L2 = (Rin*1.1474/(2*pi*fc)*k1) H
  k1 = 1.399
  C5 = (0.9471/(2*pi*fc*Rin)*k2) farad
  L3 = (Rin*1.0173/(2*pi*fc)*k2) H
  C6 = (0.1205/(2*pi*fc*Rin)*k2) farad
  C7 = (0.9471/(2*pi*fc*Rin)*k2) farad
  k2 = 1.335
components:
  A1 = IND_Q(L=L1)
  A2 = CAP_Q(c=C1)
  A3 = CAP_Q(c=C2)
  A4 = IND_Q(L=L2)
  A5 = CAP_Q(c=C3)
  A6 = CAP_Q(c=C4)
  A7 = IND_Q(L=L3)
  A8 = CAP_Q(c=C5)
  A9 = CAP_Q(c=C7)
  A10 = CAP_Q(c=C6)
  port Port1 rz=Rin iz=0ohm EnableNoise=false noisetemp=16.85cel
  port Port2 rz=Rin iz=0ohm EnableNoise=false noisetemp=16.85cel
  port Port3 rz=Rin iz=0ohm EnableNoise=false noisetemp=16.85cel
  port Port4 rz=Rin iz=0ohm EnableNoise=false noisetemp=16.85cel
  port Port5 rz=Rin iz=0ohm EnableNoise=false noisetemp=16.85cel
  port Port6 rz=Rin iz=0ohm EnableNoise=false noisetemp=16.85cel
nets:
  0: A2.0, A3.0, A6.0, A5.0, A8.0, A9.0
  Port1: A1.0, A2.1
  Port2: A1.1, A3.1
  Port3: A5.1, A4.0
  Port4: A6.1, A4.1
  Port5: A10.1, A7.0, A8.1
  Port6: A10.0, A7.1, A9.1
setups:
  LinearFrequency: LinearFrequencyData(false, 0.1, false, "", false) SweepDefinition{Variable=Freq Data="DEC 1MHz 1GHz 100"}
reports:
  S Parameter Plot1: dB(S(Port1,Port1)), dB(S(Port2,Port1)), dB(S(Port3,Port3)), dB(S(Port4,Port3)), dB(S(Port5,Port5)), dB(S(Port6,Port5)) vs Freq on LinearFrequency : LinearFrequency; markers MX1 at x=1
