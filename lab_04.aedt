# Ansys Electronics Desktop project, version 2025.2
materials:
  copper: permeability=0.999991 conductivity=58000000
  FR4_epoxy: permittivity=4.4 dielectric_loss_tangent=0.02

design Circuit1 (Circuit)
options: SParamCircuitDef IntegrationMethod=FFT
variables:
  wr = 1.5mm
  l1 = 0.8mm
  L = 24.2mm
  sp = 0.92mm
components:
  A1 = MS_TRL(W=wr P=L-l1)
  A2 = MS_TRL(W=wr P=l1)
  A3 = MS_VIAHOLE()
  A4 = MS_VIAHOLE()
  A5 = MS_VIAHOLE()
  C6 = CAP_()
  A7 = MS_MCPL02(W=wr P=L-l1 SP=sp)
  A8 = MS_MCPL02(W=wr P=l1 SP=sp)
  A6 = MS_VIAHOLE()
  A9 = MS_VIAHOLE()
  A10 = MS_VIAHOLE()
  A11 = MS_VIAHOLE()
  A12 = MS_VIAHOLE()
  C1 = CAP_()
  A13 = MS_VIAHOLE()
  C2 = CAP_()
  A30 = MS_MCPL03(W=wr P=L-l1 SP=sp)
  A31 = MS_MCPL03(W=wr P=l1 SP=sp)
  A14 = MS_VIAHOLE()
  A15 = MS_VIAHOLE()
  A16 = MS_VIAHOLE()
  A17 = MS_VIAHOLE()
  A18 = MS_VIAHOLE()
  A19 = MS_VIAHOLE()
  A20 = MS_VIAHOLE()
  A21 = MS_VIAHOLE()
  A22 = MS_VIAHOLE()
  C3 = CAP_()
  C4 = CAP_()
  C5 = CAP_()
  port Port1 rz=50ohm iz=0ohm EnableNoise=false noisetemp=16.85cel
  port Port2 rz=50ohm iz=0ohm EnableNoise=false noisetemp=16.85cel
  port Port3 rz=50ohm iz=0ohm EnableNoise=false noisetemp=16.85cel
  port Port4 rz=50ohm iz=0ohm EnableNoise=false noisetemp=16.85cel
  port Port5 rz=50ohm iz=0ohm EnableNoise=false noisetemp=16.85cel
nets:
  net_1: C6.1, A3.0
  net_13: A14.0, C3.1
  net_14: A30.3, C3.0
  net_15: A30.4, C4.0
  net_16: A15.0, C4.1
  net_17: A16.0, C5.1
  net_18: A30.5, C5.0
  net_2: C6.0, A1.1
  net_20: A30.1, A31.4
  net_22: A31.0, A17.0, A18.0
  net_23: A31.1, A20.0, A19.0
  net_24: A31.2, A21.0, A22.0
  net_3: A4.0, A2.0, A5.0
  net_4: C1.1, A12.0
  net_5: A13.0, C2.1
  net_6: A9.0, A8.0, A6.0
  net_7: A8.1, A10.0, A11.0
  net_8: A7.2, C1.0
  net_9: A7.3, C2.0
  Port1: A1.0, A2.1
  Port2: A8.2, A7.0
  Port3: A8.3, A7.1
  Port4: A30.0, A31.3
  Port5: A30.2, A31.5
setups:
  LinearFrequency: LinearFrequencyData(false, 0.1, false, "", false) SweepDefinition{Variable=Freq Data="LIN 0.5GHz 2GHz 0.1MHz"}
optimetrics:
  ParametricSetup1: Parametric UseFastCalculationUpdateAlgo disabled SaveSolutions Sim._Setups=[LinearFrequency]
    sweep L: LIN 24mm 25mm 0.1mm
reports:
  S Parameter Plot1: dB(S(Port3,Port2)) vs Freq on LinearFrequency : LinearFrequency [l1=all]; markers MX1 at x=1.2283259e+09, MX2 at x=1.3670197e+09
  S Parameter Plot2: dB(S(Port4,Port4)), dB(S(Port5,Port4)) vs Freq on LinearFrequency : LinearFrequency
