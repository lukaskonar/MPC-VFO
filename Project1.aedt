# Ansys Electronics Desktop project, version 2025.2
materials:
  copper: permeability=0.999991 conductivity=58000000
  FR4_epoxy: permittivity=4.4 dielectric_loss_tangent=0.02

design Circuit1 (Circuit)
options: SParamCircuitDef IntegrationMethod=FFT
components:
  S1 = 08CS240()
  C2 = CAP_(C=9.2pF)
  C3 = CAP_(C=9.2pF)
  C1 = CAP_(C=9.2pF)
  C4 = CAP_(C=9.2pF)
  L12 = IND_(L=25nH)
  port Port1 rz=50ohm iz=0ohm EnableNoise=false noisetemp=16.85cel
  port Port2 rz=50ohm iz=0ohm EnableNoise=false noisetemp=16.85cel
  port Port3 rz=50ohm iz=0ohm EnableNoise=false noisetemp=16.85cel
  port Port4 rz=50ohm iz=0ohm EnableNoise=false noisetemp=16.85cel
nets:
  0: C2.0, C3.0, C4.0, C1.0
  Port1: S1.1, C2.1
  Port2: S1.2, C3.1
  Port3: L12.0, C1.1
  Port4: L12.1, C4.1
setups:
  LinearFrequency: LinearFrequencyData(false, 0.1, false, "", false) SweepDefinition{Variable=Freq Data="DEC 0.1MHz 10GHz 100"}
reports:
  S Parameter Plot1: dB(S(Port1,Port1)), dB(S(Port2,Port1)) vs Freq on LinearFrequency : LinearFrequency
  S Parameter Plot2: dB(S(Port3,Port3)), dB(S(Port4,Port3)) vs Freq on LinearFrequency : LinearFrequency
  S Parameter Plot3: dB(S(Port1,Port1)), dB(S(Port2,Port1)), dB(S(Port3,Port4)), dB(S(Port4,Port4)) vs Freq on LinearFrequency : LinearFrequency; markers MX1 at x=1e+10
