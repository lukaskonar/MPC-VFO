# Ansys Electronics Desktop project, version 2025.2
materials:
  copper: permeability=0.999991 conductivity=58000000
  FR4_epoxy: permittivity=4.4 dielectric_loss_tangent=0.02

design Circuit1 (Circuit)
options: SParamCircuitDef IntegrationMethod=FFT
variables:
  l1 = 0nH  # tune 0nH..5nH
  Rs = 14ohm  # tune 0ohm..200ohm
  Rp = 56ohm  # tune 25ohm..500ohm
  p1 = 10mm  # tune 5mm..15mm
  cp = 3.3pF  # tune 1.65pF..4.95pF
components:
  S1 = BFP720ESD_w_noise_VCE_3()
  L2 = IND_(L=l1)
  R3 = RES_(R=Rs)
  R4 = RES_(R=Rp)
  C1 = CAP_(C=100pF)
  C2 = CAP_(C=100pF)
  C3 = CAP_(C=100pF)
  A18 = MS_TRL(W=1.45mm P=p1)
  L1 = IND_(L=4nH)
  C4 = CAP_(C=cp)
  port Port1 rz=50ohm iz=0ohm EnableNoise=false noisetemp=16.85cel
  port Port2 rz=50ohm iz=0ohm EnableNoise=false noisetemp=16.85cel
nets:
  0: L2.1, C1.0, C2.1, C4.0
  net_1: L2.0, S1.ref
  net_10: L1.1, S1.1, C4.1, A18.1
  net_11: C3.1, A18.0
  net_2: R3.0, S1.2, R4.1
  net_7: L1.0, C1.1
  net_8: R4.0, C2.0
  Port1: C3.0
  Port2: R3.1
setups:
  LinearFrequency: LinearFrequencyData(false, 0.1, true, "", false) SweepDefinition{Variable=Freq Data="LIN 50MHz 3.5GHz 50MHz"}
reports:
  S Parameter Plot1: dB(S(Port1,Port1)), dB(S(Port2,Port1)), dB(S(Port2,Port2)), dB(MSG), dB(GMAX), dB(NF), FMIN vs Freq on LinearFrequency : LinearFrequency; markers MX1 at x=2.397474e+09
  Stability Plot1: K, B1, K vs Freq on LinearFrequency : LinearFrequency
  S Parameter Chart1: S(Port1,Port1), S(Port2,Port2) on LinearFrequency : LinearFrequency [Freq=all]
  S-Parameters: S(Port1,Port1) on LinearFrequency : LinearFrequency [Freq=all]; KCS, KCL on LinearFrequency : LinearFrequency [Freq=2.4GHz]
  S-Parameters1: S(Port1,Port1) on LinearFrequency : LinearFrequency [Freq=all]
  S-Parameters2: S(Port1,Port1) on LinearFrequency : LinearFrequency [Freq=all]
